** sch_path: /home/designer/shared/2026/Cells/QDLL.sch
.subckt QDLL VDD VSS IN1 OUT1 OUT2 IN2
*.PININFO VDD:B VSS:B IN1:I OUT1:O IN2:I OUT2:O
x5 VSS IN1 VDD IN2 LATCH1
x3 VSS OUT1 VDD OUT2 LATCH22
x1 VDD IN1 net1 net2 VSS VCDL
x2 VSS VDD net1 OUT1 DLINE11
x4 VDD VSS IN1 net6 OUT1 PD
x6 net6 net2 VSS CP
x7 VDD IN2 net3 net4 VSS VCDL2
x8 VSS VDD net3 OUT2 DLINE22
x9 VDD VSS IN2 net5 OUT2 PD2
x10 net5 net4 VSS CP
.ends

* expanding   symbol:  /home/designer/shared/2026/Cells/LATCH.sym # of pins=4
** sym_path: /home/designer/shared/2026/Cells/LATCH.sym
** sch_path: /home/designer/shared/2026/Cells/LATCH.sch
.subckt LATCH1 VSS V1 VDD V2
*.PININFO VDD:B VSS:B V1:B V2:B
x1 V2 V1 VDD VSS sg13g2_inv_1
x2 V1 V2 VDD VSS sg13g2_inv_1
.ends

* expanding   symbol:  /home/designer/shared/2026/Cells/LATCH.sym # of pins=4
** sym_path: /home/designer/shared/2026/Cells/LATCH.sym
** sch_path: /home/designer/shared/2026/Cells/LATCH.sch
.subckt LATCH22 VSS V1 VDD V2
*.PININFO VDD:B VSS:B V1:B V2:B
x1 V2 V1 VDD VSS sg13g2_inv_1
x2 V1 V2 VDD VSS sg13g2_inv_1
.ends

* expanding   symbol:  /home/designer/shared/2026/Cells/VCDL.sym # of pins=5
** sym_path: /home/designer/shared/2026/Cells/VCDL.sym
** sch_path: /home/designer/shared/2026/Cells/VCDL.sch
.subckt VCDL VDD VIN VOUT VCONT VSS
*.PININFO VDD:B VSS:B VIN:I VCONT:I VOUT:O
M1 VOUT VIN net3 VSS sg13_lv_nmos w=2u l=0.13u ng=1 m=1
M2 net3 VCONT VSS VSS sg13_lv_nmos w=3.5u l=0.18u ng=1 m=1
M3 net1 VCONT VSS VSS sg13_lv_nmos w=2u l=0.25u ng=1 m=1
M4 VOUT VIN net2 VDD sg13_lv_pmos w=4.46u l=0.13u ng=1 m=1
M5 net2 net1 VDD VDD sg13_lv_pmos w=2.24u l=0.13u ng=1 m=1
M6 net1 net1 VDD VDD sg13_lv_pmos w=2.24u l=0.13u ng=1 m=1
.ends
* expanding   symbol:  /home/designer/shared/2026/Cells/VCDL.sym # of pins=5
** sym_path: /home/designer/shared/2026/Cells/VCDL.sym
** sch_path: /home/designer/shared/2026/Cells/VCDL.sch
.subckt VCDL2 VDD VIN VOUT VCONT VSS
*.PININFO VDD:B VSS:B VIN:I VCONT:I VOUT:O
M1 VOUT VIN net3 VSS sg13_lv_nmos w=2u l=0.13u ng=1 m=1
M2 net3 VCONT VSS VSS sg13_lv_nmos w=3.5u l=0.18u ng=1 m=1
M3 net1 VCONT VSS VSS sg13_lv_nmos w=2u l=0.25u ng=1 m=1
M4 VOUT VIN net2 VDD sg13_lv_pmos w=4.46u l=0.13u ng=1 m=1
M5 net2 net1 VDD VDD sg13_lv_pmos w=2.24u l=0.13u ng=1 m=1
M6 net1 net1 VDD VDD sg13_lv_pmos w=2.24u l=0.13u ng=1 m=1
.ends

* expanding   symbol:  /home/designer/shared/2026/Cells/DLine.sym # of pins=4
** sym_path: /home/designer/shared/2026/Cells/DLine.sym
** sch_path: /home/designer/shared/2026/Cells/DLine.sch
.subckt DLINE11 VSS VDD VIN VOUT
*.PININFO VOUT:O VIN:I VDD:B VSS:B
x2 net1 net4 VDD VSS sg13g2_inv_4
x3 net2 net1 VDD VSS sg13g2_inv_8
x4 VOUT net2 VDD VSS sg13g2_inv_16
x5 net3 VIN VDD VSS sg13g2_dlygate4sd3_1
x6 net4 net3 VDD VSS sg13g2_dlygate4sd2_1
.ends

* expanding   symbol:  /home/designer/shared/2026/Cells/DLine.sym # of pins=4
** sym_path: /home/designer/shared/2026/Cells/DLine.sym
** sch_path: /home/designer/shared/2026/Cells/DLine.sch
.subckt DLINE22 VSS VDD VIN VOUT
*.PININFO VOUT:O VIN:I VDD:B VSS:B
x2 net1 net4 VDD VSS sg13g2_inv_4
x3 net2 net1 VDD VSS sg13g2_inv_8
x4 VOUT net2 VDD VSS sg13g2_inv_16
x5 net3 VIN VDD VSS sg13g2_dlygate4sd3_1
x6 net4 net3 VDD VSS sg13g2_dlygate4sd2_1
.ends

* expanding   symbol:  /home/designer/shared/2026/Cells/PD.sym # of pins=5
** sym_path: /home/designer/shared/2026/Cells/PD.sym
** sch_path: /home/designer/shared/2026/Cells/PD.sch
.subckt PD VDD VSS PDIN1 PDOUT PDIN2
*.PININFO VDD:B VSS:B PDOUT:O PDIN1:I PDIN2:I
x1 PDOUT PDIN1 PDIN2 VDD VSS sg13g2_xor2_1
.ends

* expanding   symbol:  /home/designer/shared/2026/Cells/PD.sym # of pins=5
** sym_path: /home/designer/shared/2026/Cells/PD.sym
** sch_path: /home/designer/shared/2026/Cells/PD.sch
.subckt PD2 VDD VSS PDIN1 PDOUT PDIN2
*.PININFO VDD:B VSS:B PDOUT:O PDIN1:I PDIN2:I
x1 PDOUT PDIN1 PDIN2 VDD VSS sg13g2_xor2_1
.ends

* expanding   symbol:  /home/designer/shared/2026/Cells/CP.sym # of pins=3
** sym_path: /home/designer/shared/2026/Cells/CP.sym
** sch_path: /home/designer/shared/2026/Cells/CP.sch
.subckt CP CPIN CPOUT VSS
*.PININFO VSS:B CPIN:I CPOUT:O
C1 CPOUT VSS cap_cmim w=60e-6 l=20e-6 m=1
x4 CPOUT CPIN RES
.ends

* expanding   symbol:  /home/designer/shared/2026/Cells/RES.sym # of pins=2
** sym_path: /home/designer/shared/2026/Cells/RES.sym
** sch_path: /home/designer/shared/2026/Cells/RES.sch
.subckt RES ROUT RIN
*.PININFO RIN:I ROUT:O
R1 net1 RIN  rppd w=1e-6 l=10e-6 m=1 b=0
R3 net2 net1  rppd w=1e-6 l=10e-6 m=1 b=0
R4 net3 net2 rppd w=1e-6 l=10e-6 m=1 b=0
R5 net4 net3  rppd w=1e-6 l=10e-6 m=1 b=0
R2 net5 net4  rppd w=1e-6 l=10e-6 m=1 b=0
R6 net6 net5  rppd w=1e-6 l=10e-6 m=1 b=0
R7 net7 net6  rppd w=1e-6 l=10e-6 m=1 b=0
R8 net8 net7 rppd w=1e-6 l=10e-6 m=1 b=0
R9 net9 net8  rppd w=1e-6 l=10e-6 m=1 b=0
R10 net10 net9  rppd w=1e-6 l=10e-6 m=1 b=0
R11 net11 net10  rppd w=1e-6 l=10e-6 m=1 b=0
R12 ROUT net11  rppd w=1e-6 l=10e-6 m=1 b=0
.ends

* Library name: sg13g2_stdcell
* Cell name: sg13g2_dlygate4sd3_1
* View name: schematic
.subckt sg13g2_dlygate4sd3_1 X A VDD VSS
MP3 X net3 VDD VDD sg13_lv_pmos w=1.12u l=130.00n ng=1 ad=3.808e-13 as=3.808e-13 pd=2.92e-06 ps=2.92e-06 m=1
MP2 net3 net2 VDD VDD sg13_lv_pmos w=1.000u l=500.0n ng=1 ad=3.4e-13 as=3.4e-13 pd=2.68e-06 ps=2.68e-06 m=1
MP1 net2 net1 VDD VDD sg13_lv_pmos w=1.000u l=500.0n ng=1 ad=3.4e-13 as=3.4e-13 pd=2.68e-06 ps=2.68e-06 m=1
MP0 net1 A VDD VDD sg13_lv_pmos w=420.00n l=130.00n ng=1 ad=1.428e-13 as=1.428e-13 pd=1.52e-06 ps=1.52e-06 m=1
MN3 X net3 VSS VSS sg13_lv_nmos w=740.00n l=130.00n ng=1 ad=2.516e-13 as=2.516e-13 pd=2.16e-06 ps=2.16e-06 m=1
MN2 net3 net2 VSS VSS sg13_lv_nmos w=420.00n l=500.0n ng=1 ad=1.428e-13 as=1.428e-13 pd=1.52e-06 ps=1.52e-06 m=1
MN1 net2 net1 VSS VSS sg13_lv_nmos w=420.00n l=500.0n ng=1 ad=1.428e-13 as=1.428e-13 pd=1.52e-06 ps=1.52e-06 m=1
MN0 net1 A VSS VSS sg13_lv_nmos w=420.00n l=130.00n ng=1 ad=1.428e-13 as=1.428e-13 pd=1.52e-06 ps=1.52e-06 m=1
.ends
* End of subcircuit definition.

* Library name: sg13g2_stdcell
* Cell name: sg13g2_dlygate4sd2_1
* View name: schematic
.subckt sg13g2_dlygate4sd2_1 X A VDD VSS
MP3 X net3 VDD VDD sg13_lv_pmos w=1.12u l=130.00n ng=1 ad=3.808e-13 as=3.808e-13 pd=2.92e-06 ps=2.92e-06 m=1
MP2 net3 net2 VDD VDD sg13_lv_pmos w=1.000u l=250.00n ng=1 ad=3.4e-13 as=3.4e-13 pd=2.68e-06 ps=2.68e-06 m=1
MP1 net2 net1 VDD VDD sg13_lv_pmos w=1.000u l=250.00n ng=1 ad=3.4e-13 as=3.4e-13 pd=2.68e-06 ps=2.68e-06 m=1
MP0 net1 A VDD VDD sg13_lv_pmos w=420.00n l=130.00n ng=1 ad=1.428e-13 as=1.428e-13 pd=1.52e-06 ps=1.52e-06 m=1
MN3 X net3 VSS VSS sg13_lv_nmos w=740.00n l=130.00n ng=1 ad=2.516e-13 as=2.516e-13 pd=2.16e-06 ps=2.16e-06 m=1
MN2 net3 net2 VSS VSS sg13_lv_nmos w=420.00n l=180.00n ng=1 ad=1.428e-13 as=1.428e-13 pd=1.52e-06 ps=1.52e-06 m=1
MN1 net2 net1 VSS VSS sg13_lv_nmos w=420.00n l=180.00n ng=1 ad=1.428e-13 as=1.428e-13 pd=1.52e-06 ps=1.52e-06 m=1
MN0 net1 A VSS VSS sg13_lv_nmos w=420.00n l=130.00n ng=1 ad=1.428e-13 as=1.428e-13 pd=1.52e-06 ps=1.52e-06 m=1
.ends
* End of subcircuit definition.

* Library name: sg13g2_stdcell
* Cell name: sg13g2_inv_4
* View name: schematic
.subckt sg13g2_inv_4 Y A VDD VSS
MP0 Y A VDD VDD sg13_lv_pmos w=4.48u l=130.00n ng=4 ad=8.512e-13 as=1.187e-12 pd=6e-06 ps=8.84e-06 m=1
MN0 Y A VSS VSS sg13_lv_nmos w=2.96u l=130.00n ng=4 ad=5.624e-13 as=7.844e-13 pd=4.48e-06 ps=6.56e-06 m=1
.ends
* End of subcircuit definition.

* Library name: sg13g2_stdcell
* Cell name: sg13g2_inv_8
* View name: schematic
.subckt sg13g2_inv_8 Y A VDD VSS
MN1 Y A VSS VSS sg13_lv_nmos w=5.92u l=130.00n ng=8 ad=1.125e-12 as=1.347e-12 pd=8.96e-06 ps=1.104e-05 m=1
MP0 Y A VDD VDD sg13_lv_pmos w=8.96u l=130.00n ng=8 ad=1.702e-12 as=2.038e-12 pd=1.2e-05 ps=1.484e-05 m=1
.ends
* End of subcircuit definition.

* Library name: sg13g2_stdcell
* Cell name: sg13g2_inv_16
* View name: schematic
.subckt sg13g2_inv_16 Y A VDD VSS
MN1 Y A VSS VSS sg13_lv_nmos w=11.84u l=130.00n ng=16 ad=2.25e-12 as=2.472e-12 pd=1.792e-05 ps=2e-05 m=1
MP0 Y A VDD VDD sg13_lv_pmos w=17.92u l=130.00n ng=16 ad=3.405e-12 as=3.741e-12 pd=2.4e-05 ps=2.684e-05 m=1
.ends
* End of subcircuit definition.

* Library name: sg13g2_stdcell
* Cell name: sg13g2_inv_1
* View name: schematic
.subckt sg13g2_inv_1 Y A VDD VSS
MN1 Y A VSS VSS sg13_lv_nmos w=740.00n l=130.00n ng=1 ad=2.516e-13 as=2.516e-13 pd=2.16e-06 ps=2.16e-06 m=1
MP0 Y A VDD VDD sg13_lv_pmos w=1.12u l=130.00n ng=1 ad=3.808e-13 as=3.808e-13 pd=2.92e-06 ps=2.92e-06 m=1
.ends
* End of subcircuit definition.

* Library name: sg13g2_stdcell
* Cell name: sg13g2_xor2_1
* View name: schematic
.subckt sg13g2_xor2_1 X A B VDD VSS
MN0 net1 A VSS VSS sg13_lv_nmos w=550.00n l=130.00n ng=1 ad=1.87e-13 as=1.87e-13 pd=1.78e-06 ps=1.78e-06 m=1
MN4 X B net3 VSS sg13_lv_nmos w=740.00n l=130.00n ng=1 ad=2.516e-13 as=2.516e-13 pd=2.16e-06 ps=2.16e-06 m=1
MN6 X net1 VSS VSS sg13_lv_nmos w=740.00n l=130.00n ng=1 ad=2.516e-13 as=2.516e-13 pd=2.16e-06 ps=2.16e-06 m=1
MN8 net3 A VSS VSS sg13_lv_nmos w=740.00n l=130.00n ng=1 ad=2.516e-13 as=2.516e-13 pd=2.16e-06 ps=2.16e-06 m=1
MN9 net1 B VSS VSS sg13_lv_nmos w=550.00n l=130.00n ng=1 ad=1.87e-13 as=1.87e-13 pd=1.78e-06 ps=1.78e-06 m=1
MP1 net6 A VDD VDD sg13_lv_pmos w=1.000u l=130.00n ng=1 ad=3.4e-13 as=3.4e-13 pd=2.68e-06 ps=2.68e-06 m=1
MP2 net1 B net6 VDD sg13_lv_pmos w=1.000u l=130.00n ng=1 ad=3.4e-13 as=3.4e-13 pd=2.68e-06 ps=2.68e-06 m=1
MP3 net5 A VDD VDD sg13_lv_pmos w=1.12u l=130.00n ng=1 ad=3.808e-13 as=3.808e-13 pd=2.92e-06 ps=2.92e-06 m=1
MP5 net5 B VDD VDD sg13_lv_pmos w=1.12u l=130.00n ng=1 ad=3.808e-13 as=3.808e-13 pd=2.92e-06 ps=2.92e-06 m=1
MP7 X net1 net5 VDD sg13_lv_pmos w=1.12u l=130.00n ng=1 ad=3.808e-13 as=3.808e-13 pd=2.92e-06 ps=2.92e-06 m=1
.ends
* End of subcircuit definition.
.ends
