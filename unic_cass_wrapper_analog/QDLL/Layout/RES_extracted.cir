* Extracted by KLayout with SG13G2 LVS runset on : 07/03/2026 12:56

.SUBCKT RES
R$12 \$2 \$25 rppd w=1u l=120u ps=0 b=0 m=1
.ENDS RES
