* Extracted by KLayout with SG13G2 LVS runset on : 07/03/2026 16:25

.SUBCKT CP VSS CPOUT CPIN
R$12 CPIN CPOUT rppd w=1u l=120u ps=0 b=0 m=1
C$13 CPOUT VSS cap_cmim w=60u l=20u A=1200p P=160u m=1
.ENDS CP
